* Circuito em malha/escada expandido para teste de escalabilidade
* Contem 5 nos independentes (1 a 5) mais a referencia GND (0)
* Total: 10 resistores
* Formato: R<nome> <no_a> <no_b> <valor_ohms>

R1  1 0 100
R2  1 2 50
R3  2 0 150
R4  2 3 100
R5  3 0 200
R6  3 4 50
R7  4 0 250
R8  4 5 100
R9  5 0 300
R10 1 3 200
