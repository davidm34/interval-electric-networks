* Circuito com resistores e fontes de corrente
* Formato Resistor: R<nome> <no_a> <no_b> <valor_ohms>
* Formato Corrente: I<nome> <no_+> <no_-> <valor_A>
* <no_+> nó que sai
* <no_-> nó que entra

R1  1 0 100
R2  1 2 50
R3  2 0 150
R4  2 3 100
R5  3 0 200
I1 0 1 5
I2 2 3 2
